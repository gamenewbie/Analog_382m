// Design: Analog_382m/Transit_Frequency_Analysis
simulator lang=spectre
global 0
parameters vg=1.5 L=1e-06
include "/home/ecelrc/students/kz5348/Analog_382m/Analog_382m/Modelfile_180n.scs"

// Analog_382m/Transit_Frequency_Analysis/schematic
V3 (vdc net2) vsource dc=vg type=dc
V4 (vdc net3) vsource dc=900.0m type=dc
V2 (net1 0) vsource dc=vg type=dc
V1 (vdc 0) vsource dc=1.8 type=dc
V0 (vdc2 0) vsource dc=0.9V type=dc
M0 (vdc2 net1 0 0) nch w=10u l=L
M1 (net3 net2 vdc vdc) pch w=10u l=L
simulatorOptions options temp=27
dcOp dc
dc dc param=vg start=0 stop=1.5
save M0:s M0:g M0:b M0:d M1:s M1:g M1:b M1:d
save M0:cdb M0:cgd M0:id M0:vth M0:vgs M0:gds M0:gm M0:cgg M1:cdb M1:cgd M1:id M1:vth M1:vgs M1:gds M1:gm M1:cgg
